* === NOR2 Una conmuta ===
.include 45nm_HP.pm
.param VDDv = 1.0
.param Lmin = 45n
.param Wn = 4*Lmin
.param beta = 2.5 ; beta optimo del inversor de referencia

V1 vdd 0 DC {VDDv}
VA a 0 0
VB b 0 PULSE(0 {VDDv} 1n 10p 10p 2n 4n)

*--- PUN: PMOS en SERIE ---
MP1 y a vdd vdd pmos L={Lmin} W={2*beta*Wn}
MP2 out b y vdd pmos L={Lmin} W={2*beta*Wn}

*--- PDN: NMOS en PARALELO ---
MN1 out a 0 0 nmos L={Lmin} W={Wn}
MN2 out b 0 0 nmos L={Lmin} W={Wn}

C1 out 0 2f
.tran 0 8n 0 0.5p

.meas tran tpHL TRIG V(b) VAL={VDDv/2} RISE=1 TARG V(out) VAL={VDDv/2} FALL=1
.meas tran tpLH TRIG V(b) VAL={VDDv/2} FALL=1 TARG V(out) VAL={VDDv/2} RISE=1
.meas tran tp PARAM (tpHL+tpLH)/2
.end
