* === NOR2 Ambas conmutan ===
.include 45nm_HP.pm
.param VDDv = 1.0
.param Lmin = 45n
.param Wn = 4*Lmin
.param beta = 2

V1 vdd 0 {VDDv}
VA a 0 PULSE(0 {VDDv} 200p 10p 10p 1n 2n)
VB b 0 PULSE(0 {VDDv} 200p 10p 10p 1n 2n)

MN1 out a 0 0 nmos L={Lmin} W={Wn}
MN2 out b 0 0 nmos L={Lmin} W={Wn}
MP1 vdd a px vdd pmos L={Lmin} W={2*beta*Wn}
MP2 px b out vdd pmos L={Lmin} W={2*beta*Wn}

C1 out 0 2f
.tran 0 4n 0 0.5p
.meas tran tpHL TRIG V(a) VAL={VDDv/2} RISE=1 TARG V(out) VAL={VDDv/2} FALL=1
.meas tran tpLH TRIG V(a) VAL={VDDv/2} FALL=1 TARG V(out) VAL={VDDv/2} RISE=1
.end
