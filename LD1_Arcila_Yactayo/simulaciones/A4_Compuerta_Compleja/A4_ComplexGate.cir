* === A4: Compuerta Compleja AOI Y = ~((A*B)+C) ===
.include 45nm_HP.pm
.param VDDv = 1.0
.param Lmin = 45n
.param Wn = 4*Lmin
.param beta = 2

V1 vdd 0 {VDDv}
VA a 0 PULSE(0 {VDDv} 0 10p 10p 4n 8n)
VB b 0 PULSE(0 {VDDv} 0 10p 10p 2n 4n)
VC c 0 PULSE(0 {VDDv} 0 10p 10p 1n 2n)

* --- PDN: (A serie B) paralelo C
MN_A out a nab 0 nmos L={Lmin} W={2*Wn}
MN_B nab b 0   0 nmos L={Lmin} W={2*Wn}
MN_C out c 0   0 nmos L={Lmin} W={Wn}

* --- PUN: C en serie con (A paralelo B)
MP_C vdd  c pmid vdd pmos L={Lmin} W={2*beta*Wn}
MP_A pmid a out  vdd pmos L={Lmin} W={2*beta*Wn}
MP_B pmid b out  vdd pmos L={Lmin} W={2*beta*Wn}

C1 out 0 2f

.tran 0 8n 0 1p

* --- Mediciones robustas con ventana temporal (TD)
* Peor caso de subida (t = 3 ns: transicion ABC = 101 -> 100, flanco de subida en out)
.meas tran tplh_worst TRIG V(c) VAL={VDDv/2} TD=2.5n FALL=1 TARG V(out) VAL={VDDv/2} TD=2.5n RISE=1

* Descarga rapida por transistor C (t = 4 ns: transicion ABC = 100 -> 011, flanco de bajada en out)
.meas tran tphl_c     TRIG V(c) VAL={VDDv/2} TD=3.5n RISE=1 TARG V(out) VAL={VDDv/2} TD=3.5n FALL=1

* Retardo promedio representativo
.meas tran tp_avg     PARAM (tplh_worst + tphl_c)/2

.end
