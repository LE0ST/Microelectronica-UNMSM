* Caracterizacion VTC Inversor de Referencia LD2 - 45hp_85C
.include ../../modelos/ptm45hp.lib
.options gmin=1e-15 abstol=1e-14 reltol=1e-4 method=gear
.temp 85

.param VDDval = 1.0
Vdd vdd 0 {VDDval}
Vin in 0 0

MN out in 0   0   nmos_45hp W=90n L=45n
MP out in vdd vdd pmos_45hp W=135n L=45n
Cout out 0 1f

.dc Vin 0 {VDDval} 0.5m
.meas dc VM FIND V(in) WHEN V(out)=V(in)
.meas dc VOH FIND V(out) AT=0
.meas dc VOL FIND V(out) AT={VDDval}
.end
