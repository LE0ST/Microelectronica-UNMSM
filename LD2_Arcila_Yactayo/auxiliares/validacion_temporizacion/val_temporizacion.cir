* ==============================================================================
* VALIDACION DE CRITERIOS TEMPORALES: ASOCIACION DE FLANCOS Y ROBUSTEZ TD
* ==============================================================================

.include ../../modelos/ptm45hp.lib
.options gmin=1e-15 abstol=1e-14 reltol=1e-4 method=gear
.temp 27

.param VDD=1.0
.param Ln=45n Wn=90n Wp=135n
.param CL=2f
.param Tclk=2n

Vdd vdd 0 {VDD}

* Reloj y estimulos de la Actividad 1
Vclk clk 0 PULSE(0 {VDD} 0 20p 20p {Tclk/2} {Tclk})
Va a 0 PULSE(0 {VDD} {Tclk*0.55} 20p 20p {Tclk*1.9} {Tclk*4})
Vb b 0 {VDD}
Vc c 0 {VDD}

* NAND3 dinamica footed
Mp dyn clk vdd vdd pmos_45hp W={Wp} L={Ln}
M1 n1 a dyn 0 nmos_45hp W={Wn*3} L={Ln}
M2 n2 b n1  0 nmos_45hp W={Wn*3} L={Ln}
M3 n3 c n2  0 nmos_45hp W={Wn*3} L={Ln}
Mf 0 clk n3 0 nmos_45hp W={Wn*3} L={Ln}
CL dyn 0 {CL}

* Inversor domino de salida
Mpi out dyn vdd vdd pmos_45hp W={Wp} L={Ln}
Mni out dyn 0   0   nmos_45hp W={Wn} L={Ln}
Cout out 0 1f

.tran 0 {Tclk*4} 0 1p

* 1. Mediciones con conteo de flancos absolutos (segun guia)
.meas TRAN tpHL_guia   TRIG V(clk) VAL={VDD/2} RISE=2 TARG V(dyn) VAL={VDD/2} FALL=1
.meas TRAN tpLH_guia   TRIG V(clk) VAL={VDD/2} FALL=2 TARG V(dyn) VAL={VDD/2} RISE=1

* 2. Mediciones robustas con ventana temporal (TD) - aislamiento de ciclo 2
.meas TRAN tpHL_robust TRIG V(clk) VAL={VDD/2} TD=1.5n RISE=1 TARG V(dyn) VAL={VDD/2} TD=1.5n FALL=1
.meas TRAN tpLH_robust TRIG V(clk) VAL={VDD/2} TD=2.5n FALL=1 TARG V(dyn) VAL={VDD/2} TD=2.5n RISE=1

* 3. Medición del retardo global dominó (entrada de reloj -> salida del inversor out)
.meas TRAN tpd_eval    TRIG V(clk) VAL={VDD/2} TD=1.5n RISE=1 TARG V(out) VAL={VDD/2} TD=1.5n RISE=1

.end
