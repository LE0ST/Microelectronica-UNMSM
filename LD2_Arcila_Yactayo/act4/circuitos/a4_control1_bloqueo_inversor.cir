* ==============================================================================
* ACTIVIDAD 4 - CONTROL 1: Cascada Domino con Inversor - Bloqueo Correcto (X = 0)
* Demostracion de no-descarga de la segunda etapa bajo condicion de bloqueo
* Curso: Microelectronica y Sistemas Nanoelectronicos - UNMSM 2026-II
* ==============================================================================

.include ../../modelos/ptm45hp.lib

.param VDD=1.0
.param Ln=45n Wn=90n Wp=135n
.param CL=2f Cout=1f
.param Tclk=2n

.temp 27
.options gmin=1e-15 abstol=1e-14 reltol=1e-4 method=gear

* Fuentes de alimentacion y reloj
Vdd vdd 0 {VDD}
Vclk clk 0 PULSE(0 {VDD} 0 20p 20p {Tclk/2} {Tclk})

* Entradas logicas: A=B=1 (Etapa 1 conmuta), X=0 (Etapa 2 bloqueada)
Va a 0 {VDD}
Vb b 0 {VDD}
Vx x 0 0

* --- Etapa 1: NAND2 dinamica footed ---
Mp1 dyn1 clk vdd vdd pmos_45hp W={Wp} L={Ln}
M11 m1 a dyn1 0 nmos_45hp W={Wn*2} L={Ln}
M12 m2 b m1 0 nmos_45hp W={Wn*2} L={Ln}
Mf1 0 clk m2 0 nmos_45hp W={Wn*2} L={Ln}
C1 dyn1 0 {CL}

* --- Inversor estatico intermedio (Estructura Domino) ---
Mpi1 out1 dyn1 vdd vdd pmos_45hp W={Wp} L={Ln}
Mni1 out1 dyn1 0 0 nmos_45hp W={Wn} L={Ln}

* --- Etapa 2: NAND2 dinamica footed gobernada por out1 y X ---
Mp2 dyn2 clk vdd vdd pmos_45hp W={Wp} L={Ln}
M21 k1 out1 dyn2 0 nmos_45hp W={Wn*2} L={Ln}
M22 k2 x k1 0 nmos_45hp W={Wn*2} L={Ln}
Mf2 0 clk k2 0 nmos_45hp W={Wn*2} L={Ln}
C2 dyn2 0 {CL}

* --- Inversor de salida de la Etapa 2 ---
Mpi2 out2 dyn2 vdd vdd pmos_45hp W={Wp} L={Ln}
Mni2 out2 dyn2 0 0 nmos_45hp W={Wn} L={Ln}
Cout2 out2 0 {Cout}

* Analisis transitorio (4 ciclos para establecimiento periodico)
.tran 0 {Tclk*4} 0 2p

* Mediciones en el Ciclo 2 de Evaluacion (t in [2.0ns, 3.0ns])
.meas TRAN Vdyn1_eval_final FIND V(dyn1) AT=2.99n
.meas TRAN Vout1_eval_final FIND V(out1) AT=2.99n
.meas TRAN Vdyn2_eval_final FIND V(dyn2) AT=2.99n
.meas TRAN Vout2_eval_final FIND V(out2) AT=2.99n
.meas TRAN Vdyn2_eval_min MIN V(dyn2) FROM=2.0n TO=3.0n
.meas TRAN delta_Vdyn2 PARAM {VDD - Vdyn2_eval_min}

.end
