* ==============================================================================
* ACTIVIDAD 3 - LD2: Ensayo de Evidencia Fallo Wkp=1nm en 130nm Bulk @ 27C
* Ensayo: ENS-A3-130-ERR-01
* Demostracion de limitacion matematica del modelo: Wint=5nm => Weff <= 0
* ==============================================================================

.include ../../modelos/ptm45hp.lib
.include ../../modelos/ptm45lp.lib
.include ../../modelos/ptm130.lib

.param VDD=1.3
.param Ln=130n Wn=260n Wp=390n
.param Wkp=1n
.param CL=2f Cout=1f
.param Teval_start=0.52n
.param Tret=1.0u
.param Tstop={Teval_start + Tret}
.temp 27
.options gmin=1e-15 abstol=1e-14 reltol=1e-4 method=gear

Vdd vdd 0 {VDD}
Vclk clk 0 PWL(0 0 0.5n 0 0.52n {VDD} {Tstop} {VDD})
Va a 0 0
Vb b 0 0
Vc c 0 0

.param Ad={Wn*3*260n} Pd={Wn*3+520n}

Mp dyn clk vdd vdd pmos_130 W={Wp} L={Ln}
M1 n1 a dyn 0 nmos_130 W={Wn*3} L={Ln} AS={Ad} AD={Ad} PS={Pd} PD={Pd}
M2 n2 b n1 0 nmos_130 W={Wn*3} L={Ln} AS={Ad} AD={Ad} PS={Pd} PD={Pd}
M3 n3 c n2 0 nmos_130 W={Wn*3} L={Ln} AS={Ad} AD={Ad} PS={Pd} PD={Pd}
Mf 0 clk n3 0 nmos_130 W={Wn*3} L={Ln} AS={Ad} AD={Ad} PS={Pd} PD={Pd}
CL dyn 0 {CL}

* Keeper con Wkp=1nm (provoca Weff = 1n - 2*5n = -9n <= 0)
Mk dyn out vdd vdd pmos_130 W={Wkp} L={Ln}

Mpi out dyn vdd vdd pmos_130 W={Wp} L={Ln}
Mni out dyn 0 0 nmos_130 W={Wn} L={Ln}
Cout out 0 {Cout}

.tran 0 {Tstop} 0 1n
.end
