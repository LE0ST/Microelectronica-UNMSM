* ==============================================================================
* ACTIVIDAD 3 - LD2: Piloto de Retencion - Keeper Condicional 45nm HP @ 85C
* Ensayo: ENS-A3-COND-PILOT-02
* Topologia: PMOS en serie (Mk_fb + Mk_en) con 3 inversores de retardo desde CLK
* Estimulo: Precarga hasta 0.5ns, Evaluacion/Retencion continua durante 1.0us efectivo
* Entradas: A=B=C=0 (PDN bloqueada / abierta)
* Microelectronica y Sistemas Nanoelectronicos - UNMSM 2026-II
* ==============================================================================

.include ../../modelos/ptm45hp.lib
.include ../../modelos/ptm45lp.lib
.include ../../modelos/ptm130.lib

.param VDD=1.0
.param Ln=45n Wn=90n Wp=135n
.param Wkp_fb=45n Wkp_en=45n
.param CL=2f Cout=1f
.param Teval_start=0.52n
.param Tret=1.0u
.param Tstop={Teval_start + Tret}
.temp 85
.options gmin=1e-15 abstol=1e-14 reltol=1e-4 method=gear

Vdd vdd 0 {VDD}

* --- Estimulo de Reloj (Precarga hasta 0.5ns, Evaluacion/Retencion desde 0.52ns hasta 1.00052us) ---
Vclk clk 0 PWL(0 0 0.5n 0 0.52n {VDD} {Tstop} {VDD})

* --- Entradas Fijas en 0 (PDN Abierta / Fugas Subumbral) ---
Va a 0 0
Vb b 0 0
Vc c 0 0

* --- Parametros de Geometria de Difusion ---
.param Ad={Wn*3*90n} Pd={Wn*3+180n}

* --- Transistor de Precarga ---
Mp dyn clk vdd vdd pmos_45hp W={Wp} L={Ln}

* --- Red de Descenso (PDN) Footed con Difusiones ---
M1 n1 a dyn 0 nmos_45hp W={Wn*3} L={Ln} AS={Ad} AD={Ad} PS={Pd} PD={Pd}
M2 n2 b n1 0 nmos_45hp W={Wn*3} L={Ln} AS={Ad} AD={Ad} PS={Pd} PD={Pd}
M3 n3 c n2 0 nmos_45hp W={Wn*3} L={Ln} AS={Ad} AD={Ad} PS={Pd} PD={Pd}
Mf 0 clk n3 0 nmos_45hp W={Wn*3} L={Ln} AS={Ad} AD={Ad} PS={Pd} PD={Pd}

* --- Capacitancia de Carga Externa ---
CL dyn 0 {CL}

* --- Inversor Domino de Salida ---
Mpi out dyn vdd vdd pmos_45hp W={Wp} L={Ln}
Mni out dyn 0 0 nmos_45hp W={Wn} L={Ln}
Cout out 0 {Cout}

* --- CADENA DE 3 INVERSORES DE RETARDO DESDE CLK ---
* Etapa 1: clk -> d1
Mpinv1 d1 clk vdd vdd pmos_45hp W={Wp} L={Ln}
Mninv1 d1 clk 0 0 nmos_45hp W={Wn} L={Ln}

* Etapa 2: d1 -> d2
Mpinv2 d2 d1 vdd vdd pmos_45hp W={Wp} L={Ln}
Mninv2 d2 d1 0 0 nmos_45hp W={Wn} L={Ln}

* Etapa 3: d2 -> d3 (senal de habilitacion activa en bajo)
Mpinv3 d3 d2 vdd vdd pmos_45hp W={Wp} L={Ln}
Mninv3 d3 d2 0 0 nmos_45hp W={Wn} L={Ln}

* --- KEEPER CONDICIONAL (Dos PMOS en serie) ---
* Mk_fb: sensa la salida (out)
Mk_fb k_mid out vdd vdd pmos_45hp W={Wkp_fb} L={Ln}
* Mk_en: habilitado por la senal de retardo d3 (activa en bajo)
Mk_en dyn d3 k_mid vdd pmos_45hp W={Wkp_en} L={Ln}

* --- Analisis Transitorio (Ventana efectiva de 1.0us) ---
.tran 0 {Tstop} 0 1n

* --- Mediciones de Tension y Umbrales en Retencion ---
.meas TRAN vdyn_start FIND V(dyn) AT={Teval_start}
.meas TRAN vdyn_end_1us FIND V(dyn) AT={Tstop}
.meas TRAN vdyn_min MIN V(dyn) FROM={Teval_start} TO={Tstop}
.meas TRAN vout_end FIND V(out) AT={Tstop}
.meas TRAN vd3_end FIND V(d3) AT={Tstop}
.meas TRAN vk_mid_end FIND V(k_mid) AT={Tstop}
.meas TRAN t_cross_0p9vdd WHEN V(dyn)={0.90*VDD} FALL=1
.meas TRAN t_cross_vdd2 WHEN V(dyn)={0.50*VDD} FALL=1

* --- Mediciones de Corriente y Consumo ---
.meas TRAN isupply_avg AVG -I(Vdd) FROM=10n TO={Tstop}
.meas TRAN irest_end FIND -Id(Mk_en) AT={Tstop}
.meas TRAN ileak_pdn_end FIND Is(M1) AT={Tstop}
.meas TRAN ik_mid_branch FIND Is(Mk_fb) AT={Tstop}

.end
