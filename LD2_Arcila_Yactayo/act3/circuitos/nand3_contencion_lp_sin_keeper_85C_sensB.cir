* ==============================================================================
* ACTIVIDAD 3 - LD2: Contencion LP Sin Keeper 85C - Sensibilidad Numerica Config B
* Ensayo: ENS-A3-LP-SENS-B-BASE
* Tecnologia: 45nm LP, Temp = 85 C, VDD = 1.1 V
* Opciones: reltol=1e-5, abstol=1e-15, gmin=1e-15, method=gear, tstep_max=0.5ps
* Microelectronica y Sistemas Nanoelectronicos - UNMSM 2026-II
* ==============================================================================

.include ../../modelos/ptm45hp.lib
.include ../../modelos/ptm45lp.lib
.include ../../modelos/ptm130.lib

.param VDD=1.1
.param Ln=45n Wn=90n Wp=135n
.param CL=2f Cout=1f
.param Tclk=2n
.temp 85
.options gmin=1e-15 abstol=1e-15 reltol=1e-5 method=gear

Vdd vdd 0 {VDD}

* --- Reloj y Entradas Activas A=B=C=1 ---
Vclk clk 0 PULSE(0 {VDD} {Tclk/2} 20p 20p {Tclk/2} {Tclk})
Va a 0 {VDD}
Vb b 0 {VDD}
Vc c 0 {VDD}

* --- Parametros de Geometria de Difusion ---
.param Ad={Wn*3*90n} Pd={Wn*3+180n}

* --- Transistor de Precarga ---
Mp dyn clk vdd vdd pmos_45lp W={Wp} L={Ln}

* --- Red de Descenso (PDN) Footed con Difusiones (4 NMOS en serie, W=270nm) ---
M1 n1 a dyn 0 nmos_45lp W={Wn*3} L={Ln} AS={Ad} AD={Ad} PS={Pd} PD={Pd}
M2 n2 b n1 0 nmos_45lp W={Wn*3} L={Ln} AS={Ad} AD={Ad} PS={Pd} PD={Pd}
M3 n3 c n2 0 nmos_45lp W={Wn*3} L={Ln} AS={Ad} AD={Ad} PS={Pd} PD={Pd}
Mf 0 clk n3 0 nmos_45lp W={Wn*3} L={Ln} AS={Ad} AD={Ad} PS={Pd} PD={Pd}

* --- Capacitancia de Carga Externa ---
CL dyn 0 {CL}

* --- Inversor Domino de Salida (Sin Keeper) ---
Mpi out dyn vdd vdd pmos_45lp W={Wp} L={Ln}
Mni out dyn 0 0 nmos_45lp W={Wn} L={Ln}
Cout out 0 {Cout}

* --- Analisis Transitorio con Paso Maximo de 0.5ps ---
.tran 0 {Tclk*3} 0 0.5p

* --- Medicion de Retardos de Evaluacion ---
.meas TRAN tpHL_dyn TRIG V(clk) VAL={VDD/2} RISE=1 TARG V(dyn) VAL={VDD/2} FALL=1
.meas TRAN tpLH_out TRIG V(clk) VAL={VDD/2} RISE=1 TARG V(out) VAL={VDD/2} RISE=1
.meas TRAN t_trig_clk WHEN V(clk)={VDD/2} RISE=1
.meas TRAN t_targ_dyn WHEN V(dyn)={VDD/2} FALL=1
.meas TRAN t_targ_out WHEN V(out)={VDD/2} RISE=1

.end
