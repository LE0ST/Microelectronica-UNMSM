* ==============================================================================
* ACTIVIDAD 3 - LD2: Control Auxiliar Sin Retardo Intencional (Fase A3.7.2)
* Ensayo: ENS-A3-COND-CTRL-01
* Topologia: Dos PMOS en serie (Mk_fb + Mk_en de 45nm) con habilitacion sin retardo (tau_delay = 0ps)
* Objetivo: Aislar experimentalmente la resistencia serie del retardo de la cadena
* Tecnologia: 45nm HP, Temp = 85 C, VDD = 1.0 V, CL = 2fF, Cout = 1fF
* Microelectronica y Sistemas Nanoelectronicos - UNMSM 2026-II
* ==============================================================================

.include ../../modelos/ptm45hp.lib
.include ../../modelos/ptm45lp.lib
.include ../../modelos/ptm130.lib

.param VDD=1.0
.param Ln=45n Wn=90n Wp=135n
.param Wkp_fb=45n Wkp_en=45n
.param CL=2f Cout=1f
.param Tclk=2n
.temp 85
.options gmin=1e-15 abstol=1e-14 reltol=1e-4 method=gear

Vdd vdd 0 {VDD}

* --- Reloj y Entradas Activas A=B=C=1 ---
* Precarga: t in [0, 1.0ns] (CLK=0). Evaluacion: t >= 1.0ns (CLK=1.0V)
Vclk clk 0 PULSE(0 {VDD} {Tclk/2} 20p 20p {Tclk/2} {Tclk})
Va a 0 {VDD}
Vb b 0 {VDD}
Vc c 0 {VDD}

* --- Habilitacion Sincrona Sin Retardo Intencional (tau_delay = 0ps) ---
* Nivel en precarga: VDD (1.0V, Mk_en en corte).
* Nivel en evaluacion: 0.0V (Mk_en habilitado).
* Flanco de caida: 20ps sincronizado exactamente con el flanco de subida de CLK (t=1.0ns).
* Cruce de VDD/2 en t = 1.010ns coincidente con CLK.
Ven en_sync 0 PULSE({VDD} 0 {Tclk/2} 20p 20p {Tclk/2} {Tclk})

* --- Parametros de Geometria de Difusion ---
.param Ad={Wn*3*90n} Pd={Wn*3+180n}

* --- Transistor de Precarga ---
Mp dyn clk vdd vdd pmos_45hp W={Wp} L={Ln}

* --- Red de Descenso (PDN) Footed (4 NMOS en serie, W=270nm) ---
M1 n1 a dyn 0 nmos_45hp W={Wn*3} L={Ln} AS={Ad} AD={Ad} PS={Pd} PD={Pd}
M2 n2 b n1 0 nmos_45hp W={Wn*3} L={Ln} AS={Ad} AD={Ad} PS={Pd} PD={Pd}
M3 n3 c n2 0 nmos_45hp W={Wn*3} L={Ln} AS={Ad} AD={Ad} PS={Pd} PD={Pd}
Mf 0 clk n3 0 nmos_45hp W={Wn*3} L={Ln} AS={Ad} AD={Ad} PS={Pd} PD={Pd}

* --- Capacitancia de Carga Externa ---
CL dyn 0 {CL}

* --- Inversor Domino de Salida ---
Mpi out dyn vdd vdd pmos_45hp W={Wp} L={Ln}
Mni out dyn 0 0 nmos_45hp W={Wn} L={Ln}
Cout out 0 {Cout}

* --- KEEPER CON DOS PMOS EN SERIE SIN CADENA RETARDADORA ---
* Mk_fb: sensa la salida (out)
Mk_fb k_mid out vdd vdd pmos_45hp W={Wkp_fb} L={Ln}
* Mk_en: habilitado por la senal sincrona en_sync (sin retardo intencional)
Mk_en dyn en_sync k_mid vdd pmos_45hp W={Wkp_en} L={Ln}

* --- Analisis Transitorio ---
.tran 0 {Tclk*3} 0 2p

* --- Mediciones de Desempeno y Retardos ---
.meas TRAN tpHL_dyn TRIG V(clk) VAL={VDD/2} RISE=1 TARG V(dyn) VAL={VDD/2} FALL=1
.meas TRAN tpLH_out TRIG V(clk) VAL={VDD/2} RISE=1 TARG V(out) VAL={VDD/2} RISE=1
.meas TRAN tau_delay_en TRIG V(clk) VAL={VDD/2} RISE=1 TARG V(en_sync) VAL={VDD/2} FALL=1

* --- Instantes Temporales de Eventos Clave ---
.meas TRAN t_clk_rise WHEN V(clk)={VDD/2} RISE=1
.meas TRAN t_en_fall WHEN V(en_sync)={VDD/2} FALL=1
.meas TRAN t_dyn_50 WHEN V(dyn)={VDD/2} FALL=1
.meas TRAN t_out_10 WHEN V(out)={0.10*VDD} RISE=1
.meas TRAN t_out_50 WHEN V(out)={0.50*VDD} RISE=1
.meas TRAN t_out_90 WHEN V(out)={0.90*VDD} RISE=1

* --- Tensiones en Instantes Clave ---
.meas TRAN vdyn_min MIN V(dyn) FROM=1.0n TO=2.0n
.meas TRAN vout_max MAX V(out) FROM=1.0n TO=2.0n
.meas TRAN vk_mid_at_dyn50 FIND V(k_mid) WHEN V(dyn)={VDD/2} FALL=1
.meas TRAN ven_at_dyn50 FIND V(en_sync) WHEN V(dyn)={VDD/2} FALL=1
.meas TRAN vout_at_dyn50 FIND V(out) WHEN V(dyn)={VDD/2} FALL=1
.meas TRAN vk_mid_at_out50 FIND V(k_mid) WHEN V(out)={VDD/2} RISE=1
.meas TRAN ven_at_out50 FIND V(en_sync) WHEN V(out)={VDD/2} RISE=1

* --- Corrientes en el Transitorio (Orientadas: Ikp hacia dyn, Ipdn saliendo de dyn) ---
.meas TRAN ikp_at_dyn50 FIND -Id(Mk_en) WHEN V(dyn)={VDD/2} FALL=1
.meas TRAN ipdn_at_dyn50 FIND Is(M1) WHEN V(dyn)={VDD/2} FALL=1
.meas TRAN ikp_max MAX -Id(Mk_en) FROM=1.0n TO=1.2n
.meas TRAN ipdn_max MAX Is(M1) FROM=1.0n TO=1.2n

.end
