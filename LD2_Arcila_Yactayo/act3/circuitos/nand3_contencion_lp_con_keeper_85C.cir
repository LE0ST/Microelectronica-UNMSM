* ==============================================================================
* ACTIVIDAD 3 - LD2: Evaluacion de Contencion en Velocidad - 45nm LP Con Keeper
* Ensayo: ENS-A3-LP-CONT-02 (Campana de 8 pasos: P01 a P08)
* Tecnologia: 45nm LP, Temp = 85 C, VDD = 1.1 V
* Microelectronica y Sistemas Nanoelectronicos - UNMSM 2026-II
* ==============================================================================

.include ../../modelos/ptm45hp.lib
.include ../../modelos/ptm45lp.lib
.include ../../modelos/ptm130.lib

.param VDD=1.1
.param Ln=45n Wn=90n Wp=135n
.param CL=2f Cout=1f
.param Tclk=2n
.temp 85
.options gmin=1e-15 abstol=1e-14 reltol=1e-4 method=gear

Vdd vdd 0 {VDD}

* --- Reloj y Entradas Activas A=B=C=1 (Descarga de dyn en Evaluacion) ---
* Precarga: t in [0, 1.0ns] (CLK=0). Evaluacion: t >= 1.0ns (CLK=1.1V)
Vclk clk 0 PULSE(0 {VDD} {Tclk/2} 20p 20p {Tclk/2} {Tclk})
Va a 0 {VDD}
Vb b 0 {VDD}
Vc c 0 {VDD}

* --- Parametros de Geometria de Difusion ---
.param Ad={Wn*3*90n} Pd={Wn*3+180n}

* --- Transistor de Precarga ---
Mp dyn clk vdd vdd pmos_45lp W={Wp} L={Ln}

* --- Red de Descenso (PDN) Footed con Difusiones ---
M1 n1 a dyn 0 nmos_45lp W={Wn*3} L={Ln} AS={Ad} AD={Ad} PS={Pd} PD={Pd}
M2 n2 b n1 0 nmos_45lp W={Wn*3} L={Ln} AS={Ad} AD={Ad} PS={Pd} PD={Pd}
M3 n3 c n2 0 nmos_45lp W={Wn*3} L={Ln} AS={Ad} AD={Ad} PS={Pd} PD={Pd}
Mf 0 clk n3 0 nmos_45lp W={Wn*3} L={Ln} AS={Ad} AD={Ad} PS={Pd} PD={Pd}

* --- Capacitancia de Carga Externa ---
CL dyn 0 {CL}

* --- Transistor Keeper Realimentado ---
Mk dyn out vdd vdd pmos_45lp W={Wkp} L={Ln}

* --- Inversor Domino de Salida ---
Mpi out dyn vdd vdd pmos_45lp W={Wp} L={Ln}
Mni out dyn 0 0 nmos_45lp W={Wn} L={Ln}
Cout out 0 {Cout}

* --- Barrido Parametrico de Wkp (10.5nm exploratorio y 15n..180n estandar) ---
.step param Wkp list 10.5n 15n 30n 45n 60n 90n 135n 180n

* --- Analisis Transitorio ---
.tran 0 {Tclk*3} 0 2p

* --- Medicion de Retardos de Evaluacion (Flanco ascendente de CLK en t=1.0ns) ---
.meas TRAN tpHL_dyn TRIG V(clk) VAL={VDD/2} RISE=1 TARG V(dyn) VAL={VDD/2} FALL=1
.meas TRAN tpLH_out TRIG V(clk) VAL={VDD/2} RISE=1 TARG V(out) VAL={VDD/2} RISE=1
.meas TRAN toff_kp WHEN V(out)={VDD-0.587} RISE=1

.end
