* ==============================================================================
* ACTIVIDAD 3 - LD2: Retencion Directa en la Frontera de Contencion (35nm a 40nm)
* Ensayo: ENS-A3-RET-FRONTERA-85 (Campana de 6 puntos: P01 a P06)
* Tecnologia: 45nm HP, Temp = 85 C, VDD = 1.0 V
* Microelectronica y Sistemas Nanoelectronicos - UNMSM 2026-II
* ==============================================================================

.include ../../modelos/ptm45hp.lib
.include ../../modelos/ptm45lp.lib
.include ../../modelos/ptm130.lib

.param VDD=1.0
.param Ln=45n Wn=90n Wp=135n
.param CL=2f Cout=1f
.param Teval_start=0.52n
.param Tret=1.0u
.param Tstop={Teval_start + Tret}
.temp 85
.options gmin=1e-15 abstol=1e-14 reltol=1e-4 method=gear

* --- Barrido Parametrico Discreto en la Frontera de Contencion ---
.step param Wkp list 35n 36n 37n 38n 39n 40n

Vdd vdd 0 {VDD}

* --- Reloj Detenido en Evaluacion tras Precarga ---
* Precarga: t in [0, 0.5ns] (CLK=0V)
* Conmutacion: t in [0.5ns, 0.52ns]
* Evaluacion detenida: t in [0.52ns, 1.00052us] (CLK=1.0V)
Vclk clk 0 PWL(0 0 0.5n 0 0.52n {VDD} {Tstop} {VDD})

* --- Entradas en Reposo (PDN Bloqueada para Retencion) ---
Va a 0 0
Vb b 0 0
Vc c 0 0

* --- Parametros de Geometria de Difusion ---
.param Ad={Wn*3*90n} Pd={Wn*3+180n}

* --- Transistor de Precarga ---
Mp dyn clk vdd vdd pmos_45hp W={Wp} L={Ln}

* --- Red de Descenso (PDN) Footed con Difusiones ---
M1 n1 a dyn 0 nmos_45hp W={Wn*3} L={Ln} AS={Ad} AD={Ad} PS={Pd} PD={Pd}
M2 n2 b n1 0 nmos_45hp W={Wn*3} L={Ln} AS={Ad} AD={Ad} PS={Pd} PD={Pd}
M3 n3 c n2 0 nmos_45hp W={Wn*3} L={Ln} AS={Ad} AD={Ad} PS={Pd} PD={Pd}
Mf 0 clk n3 0 nmos_45hp W={Wn*3} L={Ln} AS={Ad} AD={Ad} PS={Pd} PD={Pd}

* --- Capacitancia de Carga Externa ---
CL dyn 0 {CL}

* --- Transistor Keeper Realimentado ---
Mk dyn out vdd vdd pmos_45hp W={Wkp} L={Ln}

* --- Inversor Domino de Salida ---
Mpi out dyn vdd vdd pmos_45hp W={Wp} L={Ln}
Mni out dyn 0 0 nmos_45hp W={Wn} L={Ln}
Cout out 0 {Cout}

* --- Analisis Transitorio ---
.tran 0 {Tstop} 0 1n

* --- Mediciones de Retencion ---
.meas TRAN vdyn_start FIND V(dyn) AT={Teval_start}
.meas TRAN vdyn_end_1us FIND V(dyn) AT={Tstop}
.meas TRAN vdyn_min MIN V(dyn) FROM={Teval_start} TO={Tstop}
.meas TRAN t_cross_0p9vdd WHEN V(dyn)={0.90*VDD} FALL=1
.meas TRAN isupply_avg AVG -I(Vdd) FROM=10n TO={Tstop}
.meas TRAN ileak_pdn_avg AVG Is(M1) FROM=10n TO={Tstop}
.meas TRAN ikp_d_avg AVG Id(Mk) FROM=10n TO={Tstop}
.meas TRAN ikp_inj_avg PARAM {-ikp_d_avg}

.save V(clk) V(dyn) V(out) I(Vdd) I(CL) Id(M1) Is(M1) Id(Mp) Id(Mk) Is(Mk) Ig(Mni) Ig(Mpi)
.end
