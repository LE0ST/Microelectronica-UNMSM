* ==============================================================================
* ACTIVIDAD 1 - LD2: NAND3 Dinamica Footed con Inversor Domino (Base)
* Microelectronica y Sistemas Nanoelectronicos - UNMSM 2026-II
* ==============================================================================

.include ../../modelos/ptm45hp.lib
.include ../../modelos/ptm45lp.lib
.include ../../modelos/ptm130.lib

.param VDD=1.0
.param Ln=45n Wn=90n Wp=135n
.param Wkp=45n
.param CL=2f
.param Tclk=2n
.temp 27
.options gmin=1e-15 abstol=1e-14 reltol=1e-4 method=gear

Vdd vdd 0 {VDD}

* --- Estimulos segun Guia Oficial (Sec. 5) ---
* Reloj: periodo 2ns (500 MHz), ciclo de trabajo 50%
Vclk clk 0 PULSE(0 {VDD} 0 20p 20p {Tclk/2} {Tclk})

* Entrada A: conmuta a 0.55*Tclk (1.1ns) en el primer ciclo
Va a 0 PULSE(0 {VDD} {Tclk*0.55} 20p 20p {Tclk*1.9} {Tclk*4})
Vb b 0 {VDD}
Vc c 0 {VDD}

* --- Red Dinamica Footed ---
Mp dyn clk vdd vdd pmos_45hp W={Wp} L={Ln}
M1 n1 a dyn 0 nmos_45hp W={Wn*3} L={Ln}
M2 n2 b n1 0 nmos_45hp W={Wn*3} L={Ln}
M3 n3 c n2 0 nmos_45hp W={Wn*3} L={Ln}
Mf 0 clk n3 0 nmos_45hp W={Wn*3} L={Ln}
CL dyn 0 {CL}

* --- Inversor Domino de Salida ---
Mpi out dyn vdd vdd pmos_45hp W={Wp} L={Ln}
Mni out dyn 0 0 nmos_45hp W={Wn} L={Ln}
Cout out 0 1f

* --- Analisis Transitorio ---
.tran 0 {Tclk*8} 0 5p

* --- Mediciones de Temporizacion en Nodo Dinamico (Guia Oficial) ---
.meas TRAN tpHL_dyn TRIG V(clk) VAL={VDD/2} RISE=2 TARG V(dyn) VAL={VDD/2} FALL=1
.meas TRAN tpLH_dyn TRIG V(clk) VAL={VDD/2} FALL=2 TARG V(dyn) VAL={VDD/2} RISE=1

* --- Mediciones de Temporizacion en Salida Domino (out) ---
.meas TRAN tpLH_out TRIG V(clk) VAL={VDD/2} RISE=2 TARG V(out) VAL={VDD/2} RISE=1
.meas TRAN tpHL_out TRIG V(clk) VAL={VDD/2} FALL=2 TARG V(out) VAL={VDD/2} FALL=1

* --- Retardo Logico de Evaluacion ---
.meas TRAN tpd_eval_dyn PARAM tpHL_dyn
.meas TRAN tpd_eval_out PARAM tpLH_out

* --- Potencia Media Total Suministrada por VDD ---
.meas TRAN Pavg AVG -I(Vdd)*V(vdd) FROM={Tclk*2} TO={Tclk*8}

.end
