* ==============================================================================
* ACTIVIDAD 1 - LD2: NAND3 CMOS Estatica Equivalente (Base)
* Microelectronica y Sistemas Nanoelectronicos - UNMSM 2026-II
* ==============================================================================

.include ../../modelos/ptm45hp.lib
.include ../../modelos/ptm45lp.lib
.include ../../modelos/ptm130.lib

.param VDD=1.0
.param Ln=45n Wn=90n Wp=135n
.param Tclk=2n
.temp 27
.options gmin=1e-15 abstol=1e-14 reltol=1e-4 method=gear

Vdd vdd 0 {VDD}

* --- Estimulo: Entrada A conmuta a 500 MHz (periodo 2ns, Ton=1ns) ---
Va a 0 PULSE(0 {VDD} 0.5n 20p 20p 1n {Tclk})
Vb b 0 {VDD}
Vc c 0 {VDD}

* --- PUN: 3 PMOS en paralelo (W=Wp=135n, L=45n) ---
MPa out_stat a vdd vdd pmos_45hp W={Wp} L={Ln}
MPb out_stat b vdd vdd pmos_45hp W={Wp} L={Ln}
MPc out_stat c vdd vdd pmos_45hp W={Wp} L={Ln}

* --- PDN: 3 NMOS en serie (W=3*Wn=270n, L=45n) ---
MNa out_stat a n1_stat 0 nmos_45hp W={Wn*3} L={Ln}
MNb n1_stat b n2_stat 0 nmos_45hp W={Wn*3} L={Ln}
MNc n2_stat c 0 0 nmos_45hp W={Wn*3} L={Ln}

* --- Carga de salida (1 fF) ---
Cout out_stat 0 1f

* --- Analisis Transitorio ---
.tran 0 {Tclk*8} 0 5p

* --- Mediciones de Temporizacion en NAND3 Estatica ---
.meas TRAN tpHL_stat TRIG V(a) VAL={VDD/2} RISE=2 TARG V(out_stat) VAL={VDD/2} FALL=2
.meas TRAN tpLH_stat TRIG V(a) VAL={VDD/2} FALL=2 TARG V(out_stat) VAL={VDD/2} RISE=2

* --- Potencia Media Total Suministrada por VDD con A conmutando ---
.meas TRAN Pavg_stat_sw AVG -I(Vdd)*V(vdd) FROM={Tclk*2} TO={Tclk*8}

.end
