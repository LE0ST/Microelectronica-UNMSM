* ==============================================================================
* ACTIVIDAD 1 - LD2: NAND3 Dinamica con PDN Abierta (Vc = 0) a Tclk = 2 ns
* Evaluacion de retencion a frecuencia nominal (500 MHz)
* Microelectronica y Sistemas Nanoelectronicos - UNMSM 2026-II
* ==============================================================================

.include ../../modelos/ptm45hp.lib
.include ../../modelos/ptm45lp.lib
.include ../../modelos/ptm130.lib

.param VDD=1.0
.param Ln=45n Wn=90n Wp=135n
.param Wkp=45n
.param CL=2f
.param Tclk=2n
.temp 27
.options gmin=1e-15 abstol=1e-14 reltol=1e-4 method=gear

Vdd vdd 0 {VDD}

* --- Reloj: 500 MHz ---
Vclk clk 0 PULSE(0 {VDD} 0 20p 20p {Tclk/2} {Tclk})

* --- Entradas: A=1, B=1, C=0 (PDN Abierta por corte en M3) ---
Va a 0 {VDD}
Vb b 0 {VDD}
Vc c 0 0

* --- Red Dinamica Footed ---
Mp dyn clk vdd vdd pmos_45hp W={Wp} L={Ln}
M1 n1 a dyn 0 nmos_45hp W={Wn*3} L={Ln}
M2 n2 b n1 0 nmos_45hp W={Wn*3} L={Ln}
M3 n3 c n2 0 nmos_45hp W={Wn*3} L={Ln}
Mf 0 clk n3 0 nmos_45hp W={Wn*3} L={Ln}
CL dyn 0 {CL}

* --- Inversor Domino de Salida ---
Mpi out dyn vdd vdd pmos_45hp W={Wp} L={Ln}
Mni out dyn 0 0 nmos_45hp W={Wn} L={Ln}
Cout out 0 1f

* --- Analisis Transitorio ---
.tran 0 {Tclk*8} 0 5p

* --- Mediciones de Retencion ---
.meas TRAN Vdyn_min MIN V(dyn) FROM={Tclk*2} TO={Tclk*8}
.meas TRAN Vdyn_drop PARAM {VDD}-Vdyn_min
.meas TRAN Vout_max MAX V(out) FROM={Tclk*2} TO={Tclk*8}

.end
