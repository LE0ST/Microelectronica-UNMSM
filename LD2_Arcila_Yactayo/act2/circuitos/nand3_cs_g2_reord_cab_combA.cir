* ==============================================================================
* ACTIVIDAD 2 - LD2: Protocolo Comun G2.2a - Control de Reordenamiento PDN
* Caso 5: PDN Reordenada C-A-B (Top=C, Mid=A, Bot=B) | Vector A: A=1, B=1, C=0
* Microelectronica y Sistemas Nanoelectronicos - UNMSM 2026-II
* ==============================================================================

.include ../../modelos/ptm45hp.lib

.param VDD=1.0
.param Ln=45n Wn=90n Wp=135n
.param CL=2f
.param Tclk=2n
.temp 27
.options gmin=1e-15 abstol=1e-14 reltol=1e-4 method=gear

* --- Fuentes de Alimentacion y Reloj ---
Vdd vdd 0 {VDD}
Vclk clk 0 PULSE(0 {VDD} {Tclk/2} 20p 20p {Tclk/2} {Tclk})

* --- Estimulos de Control Comun: Vector A (A=1, B=1, C=0) ---
Va a 0 PWL(0 {VDD} 2.0n {VDD} 2.02n 0 2.98n 0 3.0n {VDD})
Vb b 0 PWL(0 {VDD} 2.0n {VDD} 2.02n 0 2.98n 0 3.0n {VDD})
Vc c 0 PWL(0 {VDD} 2.0n {VDD} 2.02n 0)

* --- Parametros de Geometria de Difusion ---
.param Ad={Wn*3*90n} Pd={Wn*3+180n}

* --- Transistor de Precarga ---
Mp dyn clk vdd vdd pmos_45hp W={Wp} L={Ln}

* --- TOPOLOGIA 3: PDN Reordenada C-A-B (C en dyn, A medio, B fondo) ---
M3 n1 c dyn 0 nmos_45hp W={Wn*3} L={Ln} AS={Ad} AD={Ad} PS={Pd} PD={Pd}
M1 n2 a n1  0 nmos_45hp W={Wn*3} L={Ln} AS={Ad} AD={Ad} PS={Pd} PD={Pd}
M2 n3 b n2  0 nmos_45hp W={Wn*3} L={Ln} AS={Ad} AD={Ad} PS={Pd} PD={Pd}
Mf 0 clk n3 0 nmos_45hp W={Wn*3} L={Ln} AS={Ad} AD={Ad} PS={Pd} PD={Pd}

* --- Carga Capacitiva Externa ---
CL dyn 0 {CL}

* --- Inversor Domino de Salida ---
Mpi out dyn vdd vdd pmos_45hp W={Wp} L={Ln}
Mni out dyn 0   0   nmos_45hp W={Wn} L={Ln}
Cout out 0 1f

* --- Analisis Transitorio ---
.tran 0 {Tclk*3} 0 2p

* --- Mediciones del Protocolo Comun ---
.meas TRAN Vdyn_pre FIND V(dyn) AT=2.99n
.meas TRAN Vn1_pre  FIND V(n1)  AT=2.99n
.meas TRAN Vn2_pre  FIND V(n2)  AT=2.99n
.meas TRAN Vn3_pre  FIND V(n3)  AT=2.99n
.meas TRAN Vout_pre FIND V(out) AT=2.99n

.meas TRAN Vdyn_fixed FIND V(dyn) AT=3.50n
.meas TRAN Vout_fixed FIND V(out) AT=3.50n

.meas TRAN Vdyn_min MIN V(dyn) FROM=3.05n TO=3.95n
.meas TRAN Vout_max MAX V(out) FROM=3.05n TO=3.95n

.meas TRAN dV_vdd PARAM {VDD}-Vdyn_min
.meas TRAN dV_pre PARAM Vdyn_pre-Vdyn_min

.meas TRAN Vdyn_end FIND V(dyn) AT=3.95n
.meas TRAN Vn1_end  FIND V(n1)  AT=3.95n
.meas TRAN Vn2_end  FIND V(n2)  AT=3.95n
.meas TRAN Vn3_end  FIND V(n3)  AT=3.95n
.meas TRAN Vout_end FIND V(out) AT=3.95n

.end
