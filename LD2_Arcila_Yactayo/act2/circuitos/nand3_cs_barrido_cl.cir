* ==============================================================================
* ACTIVIDAD 2 - LD2: Barrido Parametrico de CL (0.5fF a 4fF)
* Ensayo: ENS-A2-03
* Microelectronica y Sistemas Nanoelectronicos - UNMSM 2026-II
* ==============================================================================

.include ../../modelos/ptm45hp.lib
.include ../../modelos/ptm45lp.lib
.include ../../modelos/ptm130.lib

.param VDD=1.0
.param Ln=45n Wn=90n Wp=135n
.param Wkp=45n
.param Tclk=2n
.temp 27
.options gmin=1e-15 abstol=1e-14 reltol=1e-4 method=gear

Vdd vdd 0 {VDD}

* --- Estimulos de Control Fisico con Nodos Internos Inicialmente a 0V ---
Vclk clk 0 PULSE(0 {VDD} {Tclk/2} 20p 20p {Tclk/2} {Tclk})
Va a 0 PWL(0 {VDD} 2.0n {VDD} 2.02n 0 2.98n 0 3.0n {VDD})
Vb b 0 PWL(0 {VDD} 2.0n {VDD} 2.02n 0 2.98n 0 3.0n {VDD})
Vc c 0 PWL(0 {VDD} 2.0n {VDD} 2.02n 0)

* --- Parametros de Geometria de Difusion ---
.param Ad={Wn*3*90n} Pd={Wn*3+180n}

* --- Transistor de Precarga ---
Mp dyn clk vdd vdd pmos_45hp W={Wp} L={Ln}

* --- Red de Descenso (PDN) Footed con Difusiones ---
M1 n1 a dyn 0 nmos_45hp W={Wn*3} L={Ln} AS={Ad} AD={Ad} PS={Pd} PD={Pd}
M2 n2 b n1 0 nmos_45hp W={Wn*3} L={Ln} AS={Ad} AD={Ad} PS={Pd} PD={Pd}
M3 n3 c n2 0 nmos_45hp W={Wn*3} L={Ln} AS={Ad} AD={Ad} PS={Pd} PD={Pd}
Mf 0 clk n3 0 nmos_45hp W={Wn*3} L={Ln} AS={Ad} AD={Ad} PS={Pd} PD={Pd}

* --- Capacitancia de Carga Externa (Barrido) ---
CL dyn 0 {CL}

* --- Inversor Domino de Salida ---
Mpi out dyn vdd vdd pmos_45hp W={Wp} L={Ln}
Mni out dyn 0 0 nmos_45hp W={Wn} L={Ln}
Cout out 0 1f

* --- Barrido Parametrico Segun Guia Oficial (Sec. 6.3 Tarea 2) ---
.step param CL list 0.5f 1f 2f 4f

* --- Analisis Transitorio ---
.tran 0 {Tclk*3} 0 2p

* --- Mediciones en Cada Paso de Carga ---
.meas TRAN Vdyn_min FIND V(dyn) AT={Tclk*1.95}
.meas TRAN dV PARAM {VDD}-Vdyn_min
.meas TRAN Vdyn_eval_min MIN V(dyn) FROM=3.0n TO=4.0n
.meas TRAN dV_eval_max PARAM {VDD}-Vdyn_eval_min
.meas TRAN Vout_eval_max MAX V(out) FROM=3.0n TO=4.0n
.meas TRAN Vout_end FIND V(out) AT={Tclk*1.95}
.meas TRAN Vn1_end FIND V(n1) AT={Tclk*1.95}
.meas TRAN Vn2_end FIND V(n2) AT={Tclk*1.95}

.end
