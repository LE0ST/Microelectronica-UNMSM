* ==============================================================================
* ACTIVIDAD 2 - LD2: Evaluacion de Contencion - Caso Con Keeper Wkp=45nm
* Ensayo: ENS-A2-07b
* Microelectronica y Sistemas Nanoelectronicos - UNMSM 2026-II
* ==============================================================================

.include ../../modelos/ptm45hp.lib
.include ../../modelos/ptm45lp.lib
.include ../../modelos/ptm130.lib

.param VDD=1.0
.param Ln=45n Wn=90n Wp=135n
.param Wkp=45n
.param CL=2f
.param Tclk=2n
.temp 27
.options gmin=1e-15 abstol=1e-14 reltol=1e-4 method=gear

Vdd vdd 0 {VDD}

* --- Reloj y Entradas Activas A=B=C=1 (Descarga de dyn en Evaluacion) ---
Vclk clk 0 PULSE(0 {VDD} {Tclk/2} 20p 20p {Tclk/2} {Tclk})
Va a 0 {VDD}
Vb b 0 {VDD}
Vc c 0 {VDD}

* --- Parametros de Geometria de Difusion ---
.param Ad={Wn*3*90n} Pd={Wn*3+180n}

* --- Transistor de Precarga ---
Mp dyn clk vdd vdd pmos_45hp W={Wp} L={Ln}

* --- Red de Descenso (PDN) Footed con Difusiones ---
M1 n1 a dyn 0 nmos_45hp W={Wn*3} L={Ln} AS={Ad} AD={Ad} PS={Pd} PD={Pd}
M2 n2 b n1 0 nmos_45hp W={Wn*3} L={Ln} AS={Ad} AD={Ad} PS={Pd} PD={Pd}
M3 n3 c n2 0 nmos_45hp W={Wn*3} L={Ln} AS={Ad} AD={Ad} PS={Pd} PD={Pd}
Mf 0 clk n3 0 nmos_45hp W={Wn*3} L={Ln} AS={Ad} AD={Ad} PS={Pd} PD={Pd}

* --- Capacitancia de Carga Externa ---
CL dyn 0 {CL}

* --- Keeper Realimentado Wkp=45nm ---
Mk dyn out vdd vdd pmos_45hp W={Wkp} L={Ln}

* --- Inversor Domino de Salida ---
Mpi out dyn vdd vdd pmos_45hp W={Wp} L={Ln}
Mni out dyn 0 0 nmos_45hp W={Wn} L={Ln}
Cout out 0 1f

* --- Analisis Transitorio ---
.tran 0 {Tclk*3} 0 2p

* --- Medicion de Retardos de Evaluacion con Contencion ---
.meas TRAN tpHL_dyn TRIG V(clk) VAL={VDD/2} RISE=1 TARG V(dyn) VAL={VDD/2} FALL=1
.meas TRAN tpLH_out TRIG V(clk) VAL={VDD/2} RISE=1 TARG V(out) VAL={VDD/2} RISE=1

.end
