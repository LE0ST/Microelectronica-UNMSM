* ==============================================================================
* ACTIVIDAD 2 - LD2: Protocolo G2.2c - Mitigacion 1: Precarga Interna (W = 135 nm)
* Variante homóloga a Leonardo publicado (W = 135 nm) en Banco Sincrono Controlado
* Microelectronica y Sistemas Nanoelectronicos - UNMSM 2026-II
* ==============================================================================

.include ../../modelos/ptm45hp.lib

.param VDD=1.0
.param Ln=45n Wn=90n Wp=135n
.param Wp_aux=135n
.param CL=2f
.param Tclk=2n
.temp 27
.options gmin=1e-15 abstol=1e-14 reltol=1e-4 method=gear

* --- Fuentes de Alimentacion y Reloj ---
Vdd vdd 0 {VDD}
Vclk clk 0 PULSE(0 {VDD} {Tclk/2} 20p 20p {Tclk/2} {Tclk})

* --- Estimulos Sincronos: Vector A (A=1, B=1, C=0) ---
Va a 0 PWL(0 {VDD} 2.0n {VDD} 2.02n 0 3.00n 0 3.02n {VDD})
Vb b 0 PWL(0 {VDD} 2.0n {VDD} 2.02n 0 3.00n 0 3.02n {VDD})
Vc c 0 PWL(0 {VDD} 2.0n {VDD} 2.02n 0)

* --- Parametros de Geometria de Difusion ---
.param Ad={Wn*3*90n} Pd={Wn*3+180n}

* --- Transistor de Precarga Principal del Nodo Dinamico ---
Mp dyn clk vdd vdd pmos_45hp W={Wp} L={Ln}

* --- MITIGACION 1: PMOS de Precarga Interna en n1 y n2 (W = 135 nm) ---
Mp1 n1 clk vdd vdd pmos_45hp W={Wp_aux} L={Ln}
Mp2 n2 clk vdd vdd pmos_45hp W={Wp_aux} L={Ln}

* --- Red de Descenso (PDN) Footed ---
M1 n1 a dyn 0 nmos_45hp W={Wn*3} L={Ln} AS={Ad} AD={Ad} PS={Pd} PD={Pd}
M2 n2 b n1  0 nmos_45hp W={Wn*3} L={Ln} AS={Ad} AD={Ad} PS={Pd} PD={Pd}
M3 n3 c n2  0 nmos_45hp W={Wn*3} L={Ln} AS={Ad} AD={Ad} PS={Pd} PD={Pd}
Mf 0 clk n3 0 nmos_45hp W={Wn*3} L={Ln} AS={Ad} AD={Ad} PS={Pd} PD={Pd}

* --- Carga Capacitiva Externa ---
CL dyn 0 {CL}

* --- Inversor Domino de Salida ---
Mpi out dyn vdd vdd pmos_45hp W={Wp} L={Ln}
Mni out dyn 0   0   nmos_45hp W={Wn} L={Ln}
Cout out 0 1f

* --- Analisis Transitorio ---
.tran 0 {Tclk*3} 0 2p

* --- Mediciones del Protocolo G2.2c ---
* 1. Estado previo inmediato a la conmutacion (t = 2.99 ns)
.meas TRAN Vdyn_pre FIND V(dyn) AT=2.99n
.meas TRAN Vn1_pre  FIND V(n1)  AT=2.99n
.meas TRAN Vn2_pre  FIND V(n2)  AT=2.99n
.meas TRAN Vn3_pre  FIND V(n3)  AT=2.99n
.meas TRAN Vout_pre FIND V(out) AT=2.99n

* 2. Extremos en la ventana de evaluacion [3.02 ns, 3.95 ns]
.meas TRAN Vdyn_min MIN V(dyn) FROM=3.02n TO=3.95n
.meas TRAN Vdyn_max MAX V(dyn) FROM=3.02n TO=3.95n
.meas TRAN Vout_max MAX V(out) FROM=3.02n TO=3.95n

* 3. Caidas y Sobreimpulso
.meas TRAN dV_vdd PARAM {VDD}-Vdyn_min
.meas TRAN dV_pre PARAM Vdyn_pre-Vdyn_min
.meas TRAN V_overshoot PARAM Vdyn_max-{VDD}

* 4. Estado final de evaluacion (t = 3.95 ns)
.meas TRAN Vdyn_end FIND V(dyn) AT=3.95n
.meas TRAN Vn1_end  FIND V(n1)  AT=3.95n
.meas TRAN Vn2_end  FIND V(n2)  AT=3.95n
.meas TRAN Vn3_end  FIND V(n3)  AT=3.95n
.meas TRAN Vout_end FIND V(out) AT=3.95n

.end
