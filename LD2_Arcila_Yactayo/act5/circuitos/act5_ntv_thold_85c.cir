* Actividad 5 - EXP 3b: Tiempo de Retencion y Frecuencia Minima a 85 C
* Microelectronica y Sistemas Nanoelectronicos - UNMSM 2026-II
.include ../../modelos/ptm45hp.lib

.param Ln=45n Wn=90n Wp=135n
.param CL=2f
.param Tstop=10u

.temp 85
.options gmin=1e-15 abstol=1e-14 reltol=1e-4 method=gear

Vdd vdd 0 {VDD}

* Reloj pasa a evaluacion (VDD) en 0.52 ns y se detiene
Vclk clk 0 PWL(0 0 0.5n 0 0.52n {VDD} {Tstop} {VDD})

* PDN abierta (entradas a=b=VDD, c=0)
Va a 0 {VDD}
Vb b 0 {VDD}
Vc c 0 0

Mp1 dyn1 clk vdd vdd pmos_45hp W={Wp} L={Ln}
M11 dyn1 a n11 0 nmos_45hp W={Wn*3} L={Ln}
M12 n11 b n12 0 nmos_45hp W={Wn*3} L={Ln}
M13 n12 c n13 0 nmos_45hp W={Wn*3} L={Ln}
Mf1 n13 clk 0 0 nmos_45hp W={Wn*3} L={Ln}
CL1 dyn1 0 {CL}

Mpi1 out1 dyn1 vdd vdd pmos_45hp W={Wp} L={Ln}
Mni1 out1 dyn1 0 0 nmos_45hp W={Wn} L={Ln}

.step param VDD list 1.0 0.8 0.6 0.5 0.45 0.4 0.35 0.30 0.25

.tran 0 {Tstop} 0 10n

* Medicion de t_hold (tiempo hasta que V(dyn1) cae a VDD/2)
.meas TRAN thold_85c TRIG V(clk) VAL={VDD/2} RISE=1 TARG V(dyn1) VAL={VDD/2} FALL=1
.meas TRAN fmin_85c PARAM 1.0/(2.0*thold_85c)

.end
