* Actividad 5 - EXP 5: Energia por Conmutacion y Potencia vs VDD en NTV
* Microelectronica y Sistemas Nanoelectronicos - UNMSM 2026-II
.include ../../modelos/ptm45hp.lib

.param Ln=45n Wn=90n Wp=135n
.param CL=2f
.param Tclk=10n

.temp 27
.options gmin=1e-15 abstol=1e-14 reltol=1e-4 method=gear

Vdd vdd 0 {VDD}

* Ciclo completo de reloj: Tclk = 10 ns.
* Precarga de 0 a 5 ns (CLK = 0), Evaluacion de 5 ns a 10 ns (CLK = VDD)
Vclk clk 0 PULSE(0 {VDD} 5n 20p 20p 4.98n {Tclk})

* Entradas activas para que conmute en evaluacion
Va a 0 {VDD}
Vb b 0 {VDD}
Vc c 0 {VDD}

* Celda dinamica NAND3 con inversor estatico
Mp dyn clk vdd vdd pmos_45hp W={Wp} L={Ln}
M1 dyn a n1 0 nmos_45hp W={Wn*3} L={Ln}
M2 n1 b n2 0 nmos_45hp W={Wn*3} L={Ln}
M3 n2 c n3 0 nmos_45hp W={Wn*3} L={Ln}
Mf n3 clk 0 0 nmos_45hp W={Wn*3} L={Ln}
CL dyn 0 {CL}

Mpi out dyn vdd vdd pmos_45hp W={Wp} L={Ln}
Mni out dyn 0 0 nmos_45hp W={Wn} L={Ln}

* Keeper de referencia Wkp = 45 nm
Mk dyn out vdd vdd pmos_45hp W=45n L={Ln}

.step param VDD list 1.0 0.8 0.6 0.5 0.45 0.4 0.35

.tran 0 {Tclk} 0 5p

* Potencia instantanea de la fuente VDD
* Integracion en un ciclo completo de conmutacion (0 a Tclk = 10 ns)
.meas TRAN E_cycle INTEG -I(Vdd)*{VDD} FROM=0 TO={Tclk}
.meas TRAN P_avg AVG -I(Vdd)*{VDD} FROM=0 TO={Tclk}
.meas TRAN I_peak MAX -I(Vdd) FROM=0 TO={Tclk}

.end
