* DPT P-IGBT Test Bench - LD3 (Baseline 80A)
* Autor: Leonardo Sait Yactayo Tolentino
* Dispositivo: XPIGBT (600V, 40A TO-220, Duncan Electronics)
* Fuente: Semana_02/Material_Adicional_Semestre/05_Laboratorio_IGBT/Circuitos_y_Modelos/pigbt.lib

.include "../../../Semana_02/Material_Adicional_Semestre/05_Laboratorio_IGBT/Circuitos_y_Modelos/pigbt.lib"

XZ1 VC VG VE XPIGBT
V1 Vpulse 0 PWL(0 0 10u 0 10.1u -15 30u -15 30.1u 0 35u 0 35.1u -15 36u -15 36.1u 0 60u 0)
R1 VG Vpulse 10
R2 VE 0 0.001
V2 0 Vbus 400V
L1 VC Vbus 100u Rser=1m
D1 Vbus VC DMOD
.model DMOD D(IS=1e-12 RS=0.01 BV=800 IBV=10u CJO=100p VJ=0.7 M=0.5 TT=35n)

.tran 0 60u 0 10n uic
.options abstol=1e-9 reltol=1e-4

* Corriente y tension al final del pulso 1 (calibracion historica)
.meas tran Ic_peak_p1 MAX -I(R2) FROM 29u TO 31u
.meas tran IL_max_p1 MAX I(L1) FROM 29u TO 31u
.meas tran Vce_on_p1 AVG (V(VC)-V(VE)) FROM 28u TO 29u

* Segundo pulso: conduccion previa al apagado
.meas tran Ic_on_p2 FIND -I(R2) AT 35.95u
.meas tran Vce_on_p2 FIND (V(VE)-V(VC)) AT 35.95u

* Sobretension en el segundo apagado
.meas tran Vce_peak_p2 MAX (V(VE)-V(VC)) FROM 36.0u TO 45.0u
.meas tran Vge_peak_p2 MIN (V(VG)-V(VE)) FROM 35.0u TO 36.5u

* Retardo de apagado td(off) en 2do pulso (90% VGE=-13.5V subiendo, a 90% IC=-72.2A subiendo)
* Ic_on_p2 es ~80.2A -> 90% = 72.18A (I(R2) cruza -72.18A subiendo hacia 0)
.meas tran td_off TRIG V(VG,VE) VAL=-13.5 TD=35.9u RISE=1 TARG I(R2) VAL=-72.18 TD=35.9u RISE=1
.meas tran tf TRIG I(R2) VAL=-72.18 TD=35.9u RISE=1 TARG I(R2) VAL=-8.02 TD=35.9u RISE=1
.meas tran toff TRIG V(VG,VE) VAL=-13.5 TD=35.9u RISE=1 TARG I(R2) VAL=-8.02 TD=35.9u RISE=1

* Energia de apagado Eoff en 2do pulso
.meas tran Eoff INTEG (V(VE)-V(VC))*(-I(R2)) FROM 36.0u TO 45.0u

.end
