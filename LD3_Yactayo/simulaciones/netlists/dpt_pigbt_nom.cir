* Test PIGBT Meas
.include "../../../Semana_02/Material_Adicional_Semestre/05_Laboratorio_IGBT/Circuitos_y_Modelos/pigbt.lib"

XZ1 VC VG VE XPIGBT
V1 Vpulse 0 PWL(0 0 10.0u 0 10.1u -15 18.88u -15 18.98u 0 23.98u 0 24.08u -15 25.08u -15 25.18u 0 35.0u 0)
R1 VG Vpulse 10
R2 VE 0 0.001
V2 0 Vbus 400V
L1 VC Vbus 100u Rser=1m
D1 Vbus VC DMOD
.model DMOD D(IS=1e-12 RS=0.01 BV=800 IBV=10u CJO=100p VJ=0.7 M=0.5 TT=35n)

.tran 0 35u 0 5n uic
.options abstol=1e-9 reltol=1e-4

* Estado de conduccion previo al apagado
.meas tran Ic_on FIND -I(R2) AT 25.03u
.meas tran Vce_on FIND (V(VE)-V(VC)) AT 25.03u

* Sobretension
.meas tran Vce_peak MAX (V(VE)-V(VC)) FROM 25.08u TO 30.0u

* Retardo con TD=25.0u (TRIG VGE=-13.5V subiendo hacia 0V, TARG I(R2)=-36.012A subiendo hacia 0A)
.meas tran td_off TRIG V(VG,VE) VAL=-13.5 TD=25.0u RISE=1 TARG I(R2) VAL=-36.012 TD=25.0u RISE=1

* Tiempo de caida tf: 90% a 10%
.meas tran tf TRIG I(R2) VAL=-36.012 TD=25.0u RISE=1 TARG I(R2) VAL=-4.001 TD=25.0u RISE=1

* Tiempo de apagado toff
.meas tran toff TRIG V(VG,VE) VAL=-13.5 TD=25.0u RISE=1 TARG I(R2) VAL=-4.001 TD=25.0u RISE=1

.meas tran Eoff INTEG (V(VE)-V(VC))*(-I(R2)) FROM 25.08u TO 30.0u

.end
