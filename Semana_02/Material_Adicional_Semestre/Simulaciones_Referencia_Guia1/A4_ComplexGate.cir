* === A4: Compuerta Compleja Y = (A*B) + C ===
.include 45nm_HP.pm
.param VDDv = 1.0
.param Lmin = 45n
.param Wn = 4*Lmin
.param beta = 2

V1 vdd 0 {VDDv}
VA a 0 PULSE(0 {VDDv} 0 10p 10p 4n 8n)
VB b 0 PULSE(0 {VDDv} 0 10p 10p 2n 4n)
VC c 0 PULSE(0 {VDDv} 0 10p 10p 1n 2n)

* PDN: (A serie B) paralelo C
MN_A f_n a nab 0 nmos L={Lmin} W={2*Wn}
MN_B nab b 0 0 nmos L={Lmin} W={2*Wn}
MN_C f_n c 0 0 nmos L={Lmin} W={Wn}

* PUN: (A paralelo B) serie C
MP_C vdd c pmid vdd pmos L={Lmin} W={2*beta*Wn}
MP_A pmid a f_n vdd pmos L={Lmin} W={2*beta*Wn}
MP_B pmid b f_n vdd pmos L={Lmin} W={2*beta*Wn}

* Inversor de salida para obtener Y = (A*B) + C
MN_INV out f_n 0 0 nmos L={Lmin} W={Wn}
MP_INV out f_n vdd vdd pmos L={Lmin} W={beta*Wn}

C1 out 0 2f

.tran 0 8n 0 1p
.end
